** sch_path: /home/ananya/Desktop/Physical_verification/Lab1_inverter/xschem/inverter_1_tb.sch
**.subckt inverter_1_tb out in
*.opin out
*.ipin in
x1 net1 in out GND inverter_1
V1 in GND PULSE(0 1.8 0 100p 100p 5n 10n
V2 net1 GND 1.8
**** begin user architecture code

.lib /home/ananya/Desktop/Physical_verification/open_pdks/sky130/sky130A/libs.tech/ngspice/sky130.lib.spice tt

.control
tran 10p 40n
plot V(in) V(out)
.endc

**** end user architecture code
**.ends

* expanding   symbol:  inverter_1.sym # of pins=4
** sym_path: /home/ananya/Desktop/Physical_verification/Lab1_inverter/xschem/inverter_1.sym
** sch_path: /home/ananya/Desktop/Physical_verification/Lab1_inverter/xschem/inverter_1.sch
.subckt inverter_1 vdd in out vss
*.ipin in
*.opin out
*.iopin vdd
*.iopin vss
XM1 out in vss vss sky130_fd_pr__nfet_01v8 L=0.18 W=4.5 nf=3 ad=0.87 as=0.87 pd=7.16 ps=7.16 nrd=0.0644444444444444
+ nrs=0.0644444444444444 sa=0 sb=0 sd=0 mult=1
XM2 out in vdd vdd sky130_fd_pr__pfet_01v8 L=0.18 W=3 nf=3 ad=0.58 as=0.58 pd=5.16 ps=5.16 nrd=0.0966666666666667
+ nrs=0.0966666666666667 sa=0 sb=0 sd=0 mult=1
.ends

.GLOBAL GND
.end
