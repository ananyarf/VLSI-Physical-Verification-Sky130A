** sch_path: /home/ananya/Desktop/Physical_verification/Lab1_inverter/xschem/inverter_1.sch
.subckt inverter_1 vdd in out vss
*.PININFO in:I out:O vdd:B vss:B
XM1 out in vss vss sky130_fd_pr__nfet_01v8 L=0.18 W=4.5 nf=3
XM2 out in vdd vdd sky130_fd_pr__pfet_01v8 L=0.18 W=3 nf=3
.ends
